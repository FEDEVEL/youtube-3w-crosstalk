| TEXAS INSTRUMENTS INCORPORATED
| Standard Linear and Logic Group
| IBIS Model of SN74LVC1G17
| SINGLE SCHMITT-TRIGGER BUFFER
| This file contains package information for the following:
|  SON 6-pin (DSF) package as [Component] LVC1G17_DSF
|  SOT 5-pin (DCK) package as [Component] LVC1G17_DCK
|  SOT 5-pin (DBV) package as [Component] LVC1G17_DBV
|  NanoStar WCSP 5-pin (YEA) package as [Component] LVC1G17_YEA
|  NanoFree WCSP 5-pin (YZA) package as [Component] LVC1G17_YZA
|  NanoStar WCSP 5-pin (YEP) package as [Component] LVC1G17_YEP
|  NanoFree WCSP 5-pin (YZP) package as [Component] LVC1G17_YZP
|  DSBGA 4-pin (YZV) package as [Component] LVC1G17_YZV
| This device can be powered at the following Vccs:
|  1.8 volt Vcc
|  2.5 volt Vcc
|  3.3 volt Vcc
|  5 volt Vcc
| This file provides unique models under the [Model Selector] for each Vcc.
| For operation at a specific Vcc, select the appropriate model after each
| [Model Selector] keyword.
[IBIS Ver]   3.2
[Comment char]  |_char
[File Name]   sn74lvc1g17.ibs
[File Rev]   1.4 | d_die
[Date]   03/06/2014
[Source]
| Texas Instruments Incorporated.
| Analog-eLab Design Center, HPA
| 12500 TI Blvd
| Dallas, TX -75243
[Notes]   Revision History:
| The following is an IBIS list for the LVC1G17.
| Please contact sllibis@ti.com with questions and
| comments concerning SLL IBIS models.
| - FILE REV HISTORY
| - 1.3 YZV package added on 12/21/05
| - Due to the fact that the Device is 5.5-V Input tolarent,
|   the pulldown model has some Non-Monotonic Warnings.
| - Power clamp data deleted as there is no power-clamp diode.
| - 1.4 DSF package added 03/06/2014.
[Disclaimer]
| Property of Texas Instruments Incorporated.  Unauthorized
| reproduction and/or distribution is strictly prohibited.
| This product is protected under copyright law.
| Created  2002, (C) Copyright  2002, Texas Instruments
| Incorporated, All Rights Reserved
| UNLESS THERE IS A SIGNED, WRITTEN AGREEMENT TO THE
| CONTRARY, TEXAS INSTRUMENTS (TI) IS PROVIDING THE IBIS
| MODELS  AND WITHOUT ANY WARRANTY, EXPRESSED OR
| IMPLIED.  TI assumes no liability for:
|  1) the accuracy of the IBIS models provided to your
|   company;
|  2) the proper functioning of these IBIS Models in your
|   design or for any resulting applications; or
|  3) infringement of patents, copyrights or intellectual
|   property rights resulting from your use of these IBIS
|   models.
| TI provides IBIS Models as a service to our customers.
| You and your company shall not distribute, sell or give
| these models to anyone else without prior written
| permission from TI.
| TI reserves the right to make changes to our products or
| to discontinue any semiconductor product or service
| without notice, and advises our customers to obtain the
| latest version of relevant information to verify, before
| placing orders, that the information being relied on is
| current.
| Please be aware that your receipt and use of the IBIS
| information provided shall serve as acceptance of these
| terms and conditions.  If you do not accept these terms,
| you should return or destroy the IBIS models and any
| other accompanying information immediately.
[Copyright]
(C) Copyright 2014 Texas Instruments Incorporated.All rights reserved.
| Component LVC1G17_DSF 6-pin SON
[Component]   LVC1G17_DSF
[Manufacturer]   Texas Instruments, Inc.
[Package]
|   typ   min   max
R_pkg   0.041145   0.03325   0.04904
L_pkg   0.422435nH  0.33414nH   0.51073nH
C_pkg   0.109645pF  0.10407pF   0.11522pF
[Pin]   signal_name   model_name   R_pin   L_pin   C_pin
1   nc   nc   0.00109   0.02796nH  0.07413pF
2   A   LVC1G17_IN_50   0.03325   0.33414nH  0.10407pF
3   GND   GND   0.04429   0.45885nH  0.11133pF
4   Y   LVC1G17_OUT_50   0.04904   0.51073nH  0.11522pF
5   nc   nc   0.00037   0.03788nH  0.07652pF
6   VCC   POWER   0.04377   0.44894nH  0.11085pF
[Pin Mapping]   pulldown_ref   pullup_ref  gnd_clamp_ref   power_clamp_ref
1   NC   NC
2   gndbus   pwrbus
3   gndbus   NC
4   gndbus   pwrbus
5   NC   NC
6   NC   pwrbus
| Component LVC1G17_DCK 5-pin SOT
[Component]   LVC1G17_DCK
[Manufacturer]   Texas Instruments, Inc.
[Package]
|   typ   min   max
R_pkg   2.000e-02   1.700e-02   2.500e-02
L_pkg   9.980e-10   8.810e-10   1.069e-09
C_pkg   1.460e-13   1.180e-13   2.050e-13
[Pin]   signal_name   model_name   R_pin   L_pin   C_pin
1   nc   nc   1.900e-02   1.069e-09   1.620e-13
2   A   LVC1G17_IN   1.800e-02   8.810e-10   1.210e-13
3   GND   GND   1.700e-02   1.031e-09   2.050e-13
4   Y   LVC1G17_OUT   2.000e-02   9.600e-10   1.240e-13
5   VCC   POWER   2.500e-02   1.049e-09   1.180e-13
[Pin Mapping]   pulldown_ref   pullup_ref  gnd_clamp_ref   power_clamp_ref
1   NC   NC
2   gndbus   pwrbus
3   gndbus   NC
4   gndbus   pwrbus
5   NC   pwrbus
| Component LVC1G17_DBV 5-pin SOT
[Component]   LVC1G17_DBV
[Manufacturer]   Texas Instruments, Inc.
[Package]
|   typ   min   max
R_pkg   2.500e-02   2.100e-02   2.900e-02
L_pkg   1.529e-09   1.312e-09   1.906e-09
C_pkg   1.560e-13   1.100e-13   2.400e-13
[Pin]   signal_name   model_name   R_pin   L_pin   C_pin
1   nc   nc   2.100e-02   1.511e-09   1.440e-13
2   A   LVC1G17_IN   2.300e-02   1.312e-09   1.380e-13
3   GND   GND   2.900e-02   1.906e-09   2.400e-13
4   Y   LVC1G17_OUT   2.600e-02   1.541e-09   1.500e-13
5   VCC   POWER   2.500e-02   1.374e-09   1.100e-13
| Component LVC1G17_YEA 5-pin NanoStar WCSP
[Component]   LVC1G17_YEA
[Manufacturer]   Texas Instruments, Inc.
[Package]
|   typ   min   max
R_pkg   0.001   0.001   0.001
L_pkg   0.021nH   0.021nH   0.021nH
C_pkg   0.046pF   0.045pF   0.047pF
[Pin]   signal_name   model_name   R_pin   L_pin   C_pin
1   DNU   nc   0.001   0.021nH   0.046pF
2   A   LVC1G17_IN   0.001   0.021nH   0.047pF
3   GND   GND   0.001   0.021nH   0.046pF
4   Y   LVC1G17_OUT   0.001   0.021nH   0.045pF
5   VCC   POWER   0.001   0.021nH   0.045pF
| Component LVC1G17_YZA 5-pin NanoFree WCSP
[Component]   LVC1G17_YZA
[Manufacturer]   Texas Instruments, Inc.
[Package]
|   typ   min   max
R_pkg   0.001   0.001   0.001
L_pkg   0.021nH   0.021nH   0.021nH
C_pkg   0.046pF   0.045pF   0.047pF
[Pin]   signal_name   model_name   R_pin   L_pin   C_pin
1   DNU   nc   0.001   0.021nH   0.046pF
2   A   LVC1G17_IN   0.001   0.021nH   0.047pF
3   GND   GND   0.001   0.021nH   0.046pF
4   Y   LVC1G17_OUT   0.001   0.021nH   0.045pF
5   VCC   POWER   0.001   0.021nH   0.045pF
| Component LVC1G17_YEP 5-pin NanoStar WCSP
[Component]   LVC1G17_YEP
[Manufacturer]   Texas Instruments, Inc.
[Package]
|   typ   min   max
R_pkg   0.001   0.001   0.001
L_pkg   0.021nH   0.021nH   0.021nH
C_pkg   0.046pF   0.045pF   0.047pF
[Pin]   signal_name   model_name   R_pin   L_pin   C_pin
1   DNU   nc   0.001   0.021nH   0.046pF
2   A   LVC1G17_IN   0.001   0.021nH   0.047pF
3   GND   GND   0.001   0.021nH   0.046pF
4   Y   LVC1G17_OUT   0.001   0.021nH   0.045pF
5   VCC   POWER   0.001   0.021nH   0.045pF
| Component LVC1G17_YZP 5-pin NanoFree WCSP
[Component]   LVC1G17_YZP
[Manufacturer]   Texas Instruments, Inc.
[Package]
|   typ   min   max
R_pkg   0.001   0.001   0.001
L_pkg   0.021nH   0.021nH   0.021nH
C_pkg   0.046pF   0.045pF   0.047pF
[Pin]   signal_name   model_name   R_pin   L_pin   C_pin
1   DNU   nc   0.001   0.021nH   0.046pF
2   A   LVC1G17_IN   0.001   0.021nH   0.047pF
3   GND   GND   0.001   0.021nH   0.046pF
4   Y   LVC1G17_OUT   0.001   0.021nH   0.045pF
5   VCC   POWER   0.001   0.021nH   0.045pF
| Component LVC1G17_YZV 4-pin DSBGA
[Component]   LVC1G17_YZV
[Manufacturer]   Texas Instruments, Inc.
[Package]
|   typ   min   max
R_pkg   1.000e-03   1.000e-03   1.000e-03
L_pkg   2.600e-11   2.600e-11   2.600e-11
C_pkg   1.400e-14   1.400e-14   1.400e-14
[Pin]   signal_name   model_name   R_pin   L_pin   C_pin
1   GND   GND   1.000e-03   2.600e-11   1.400e-14
2   A   LVC1G17_IN   1.000e-03   2.600e-11   1.400e-14
3   Y   LVC1G17_OUT   1.000e-03   2.600e-11   1.400e-14
4   VCC   POWER   1.000e-03   2.600e-11   1.400e-14
| Model LVC1G17_IN
[Model Selector]   LVC1G17_IN
LVC1G17_IN_18   1.8 volt Vcc
LVC1G17_IN_25   2.5 volt Vcc
LVC1G17_IN_33   3.3 volt Vcc
LVC1G17_IN_50   5 volt Vcc
| Model LVC1G17_OUT
[Model Selector]   LVC1G17_OUT
LVC1G17_OUT_18   1.8 volt Vcc
LVC1G17_OUT_25   2.5 volt Vcc
LVC1G17_OUT_33   3.3 volt Vcc
LVC1G17_OUT_50   5 volt Vcc
| Models and submodels in the file (8): LVC1G17_IN_18 (Input), LVC1G17_IN_25 (Input), LVC1G17_IN_33 (Input), LVC1G17_IN_50 (Input), LVC1G17_OUT_18 (Output), LVC1G17_OUT_25 (Output), LVC1G17_OUT_33 (Output), LVC1G17_OUT_50 (Output)
